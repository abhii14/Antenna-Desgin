# Ansys Electronics Desktop project, version 2020.2
materials:
  vacuum: permittivity=1
  Duroid (tm): permittivity=2.2 dielectric_loss_tangent=0.0009
  pec: conductivity=1e+30
  water_sea: permittivity=81 permeability=0.999991 conductivity=4
  air: permittivity=1.0006 permeability=1.0000004

design research paper model (HFSS, DrivenModal, model units mm)
geometry:
  Substrate [Duroid (tm)] = box(corner=(-17mm, -17mm, 0mm), size=(34mm, 34mm, 0.787mm))
  GroundPlane [pec] = box(corner=(-17mm, -17mm, 0mm), size=(34mm, 34mm, -0.017mm))
  Patch = box(corner=(-12mm, -12mm, 0.787mm), size=(24mm, 24mm, 0.017mm))
  FeedLine = box(corner=(12mm, -1.165mm, 0.787mm), size=(5mm, 2.33mm, 0.017mm))
  Rectangle1 = rectangle(corner=(17mm, -1.165mm, 0mm), y_size=2.33mm, z_size=0.787mm)
  FeedLine1 = box(corner=(-1mm, 12mm, 0.787mm), size=(2.33mm, 5mm, 0.017mm))
  Via_1 = imported_body()
  Rectangle2 = rectangle(corner=(-1mm, 17mm, 0mm), z_size=0.787mm, x_size=2mm)
  FeedLine2 = box(corner=(-1mm, -12mm, 0.787mm), size=(2.33mm, -5mm, 0.017mm))
  Rectangle3 = rectangle(corner=(-1mm, -17mm, 0mm), z_size=0.787mm, x_size=2.33mm)
  FeedLine.unite(FeedLine1, FeedLine2, Patch)
  Via_2 [vacuum] = imported_body()
  Substrate.subtract(Via_1)
  RadiationBox [air] = box(corner=(-40mm, -40mm, -5mm), size=(80mm, 80mm, 40mm))
  Box1 = box(corner=(12mm, -1.165mm, 0.787mm), size=(-3mm, -0.5mm, 0.017mm))
  Box2 = box(corner=(12mm, 1.165mm, 0.787mm), size=(-3mm, 0.5mm, 0.017mm))
  Box3 = box(corner=(1.33mm, 12mm, 0.787mm), size=(0.5mm, -3mm, 0.017mm))
  Box4 = box(corner=(-1.5mm, 12mm, 0.787mm), size=(0.5mm, -3mm, 0.017mm))
  Box5 = box(corner=(1.33mm, -12mm, 0.787mm), size=(0.5mm, 3mm, 0.017mm))
  Box6 = box(corner=(-1.5mm, -12mm, 0.787mm), size=(0.5mm, 3mm, 0.017mm))
  Box1.unite(Box2..Box6)
  FeedLine.subtract(Box1)
  Box7 = box(corner=(-8mm, -10mm, 0.787mm), size=(3mm, 18mm, 0.017mm))
  Box8 = box(corner=(-5mm, -5mm, 0.787mm), size=(9mm, 2.5mm, 0.017mm))
  Box9 = box(corner=(4mm, -10mm, 0.787mm), size=(4mm, 18mm, 0.017mm))
  Box7.unite(Box8, Box9)
  FeedLine.subtract(Box7)
  Box10 [pec] = box(corner=(8mm, -6mm, 0.787mm), size=(-1mm, 11mm, 0.017mm))
  Box10.unite(FeedLine)
  Rectangle1.unite(Rectangle2, Rectangle3)
boundaries and excitations:
  Rad1: Radiation Objects=RadiationBox
